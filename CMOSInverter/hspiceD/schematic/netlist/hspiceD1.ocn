simulator( 'hspiceD )
design(	 "/home3/ugrad3/cmalone/simulation/CMOSInverter/hspiceD/schematic/netlist/netlist")
resultsDir( "/home3/ugrad3/cmalone/simulation/CMOSInverter/hspiceD/schematic" )
modelFile(
    '("/home1/fac1/amitrt/Teaching/ECE8893_LAB/FreePDK45/ncsu_basekit/models/hspice/tran_models/models_nom/NMOS_VTG.inc" "")
    '("/home1/fac1/amitrt/Teaching/ECE8893_LAB/FreePDK45/ncsu_basekit/models/hspice/tran_models/models_nom/PMOS_VTG.inc" "")
)
analysis('tran ?start "0"  ?stop "20n"  ?step "10p"  )
option(	'TEMPDC  "25.0"
)
temp( 25.0 )
run()
selectResult( 'tran )
plot(getData("/output") getData("/input") )
modelFile(
    '("/home1/fac1/amitrt/Teaching/ECE8893_LAB/FreePDK45/ncsu_basekit/models/hspice/tran_models/models_nom/NMOS_VTG.inc" "")
    '("/home1/fac1/amitrt/Teaching/ECE8893_LAB/FreePDK45/ncsu_basekit/models/hspice/tran_models/models_nom/PMOS_VTG.inc" "")
)
run()
selectResult( 'tran )
plot(getData("/input") getData("/output") )
modelFile(
    '("/home1/fac1/amitrt/Teaching/ECE8893_LAB/FreePDK45/ncsu_basekit/models/hspice/tran_models/models_nom/NMOS_VTG.inc" "")
    '("/home1/fac1/amitrt/Teaching/ECE8893_LAB/FreePDK45/ncsu_basekit/models/hspice/tran_models/models_nom/PMOS_VTG.inc" "")
)
run()
selectResult( 'tran )
plot(getData("/input") getData("/output") )
modelFile(
    '("/home1/fac1/amitrt/Teaching/ECE8893_LAB/FreePDK45/ncsu_basekit/models/hspice/tran_models/models_nom/NMOS_VTG.inc" "")
    '("/home1/fac1/amitrt/Teaching/ECE8893_LAB/FreePDK45/ncsu_basekit/models/hspice/tran_models/models_nom/PMOS_VTG.inc" "")
)
run()
selectResult( 'tran )
plot(getData("/input") getData("/output") )
modelFile(
    '("/home1/fac1/amitrt/Teaching/ECE8893_LAB/FreePDK45/ncsu_basekit/models/hspice/tran_models/models_nom/NMOS_VTG.inc" "")
    '("/home1/fac1/amitrt/Teaching/ECE8893_LAB/FreePDK45/ncsu_basekit/models/hspice/tran_models/models_nom/PMOS_VTG.inc" "")
)
analysis('dc ?source "/V2"  ?start "0"  ?stop "1"
		?stepSize ".001"  )
run()
selectResult( 'dc )
plot(getData("/input") getData("/output") )
modelFile(
    '("/home1/fac1/amitrt/Teaching/ECE8893_LAB/FreePDK45/ncsu_basekit/models/hspice/tran_models/models_nom/NMOS_VTG.inc" "")
    '("/home1/fac1/amitrt/Teaching/ECE8893_LAB/FreePDK45/ncsu_basekit/models/hspice/tran_models/models_nom/PMOS_VTG.inc" "")
)
run()
selectResult( 'dc )
plot(getData("/input") getData("/output") )
modelFile(
    '("/home1/fac1/amitrt/Teaching/ECE8893_LAB/FreePDK45/ncsu_basekit/models/hspice/tran_models/models_nom/NMOS_VTG.inc" "")
    '("/home1/fac1/amitrt/Teaching/ECE8893_LAB/FreePDK45/ncsu_basekit/models/hspice/tran_models/models_nom/PMOS_VTG.inc" "")
)
run()
selectResult( 'dc )
plot(getData("/input") getData("/output") )
modelFile(
    '("/home1/fac1/amitrt/Teaching/ECE8893_LAB/FreePDK45/ncsu_basekit/models/hspice/tran_models/models_nom/NMOS_VTG.inc" "")
    '("/home1/fac1/amitrt/Teaching/ECE8893_LAB/FreePDK45/ncsu_basekit/models/hspice/tran_models/models_nom/PMOS_VTG.inc" "")
)
analysis('tran ?start "0"  ?stop "20n"  ?step "10p"  )
run()
selectResult( 'tran )
plot(getData("/input") getData("/output") )
modelFile(
    '("/home1/fac1/amitrt/Teaching/ECE8893_LAB/FreePDK45/ncsu_basekit/models/hspice/tran_models/models_nom/NMOS_VTG.inc" "")
    '("/home1/fac1/amitrt/Teaching/ECE8893_LAB/FreePDK45/ncsu_basekit/models/hspice/tran_models/models_nom/PMOS_VTG.inc" "")
)
run()
selectResult( 'tran )
plot(getData("/input") getData("/output") )
modelFile(
    '("/home1/fac1/amitrt/Teaching/ECE8893_LAB/FreePDK45/ncsu_basekit/models/hspice/tran_models/models_nom/NMOS_VTG.inc" "")
    '("/home1/fac1/amitrt/Teaching/ECE8893_LAB/FreePDK45/ncsu_basekit/models/hspice/tran_models/models_nom/PMOS_VTG.inc" "")
)
run()
selectResult( 'tran )
plot(getData("/input") getData("/output") )
modelFile(
    '("/home1/fac1/amitrt/Teaching/ECE8893_LAB/FreePDK45/ncsu_basekit/models/hspice/tran_models/models_nom/NMOS_VTG.inc" "")
    '("/home1/fac1/amitrt/Teaching/ECE8893_LAB/FreePDK45/ncsu_basekit/models/hspice/tran_models/models_nom/PMOS_VTG.inc" "")
)
run()
selectResult( 'tran )
plot(getData("/input") getData("/output") )
